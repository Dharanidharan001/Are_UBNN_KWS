*=============================================================================
* ARe-UBNN-KWS: SKY130 Integrated Clock Gating (ICG) SPICE Simulation
* Target Standard Cell: sky130_fd_sc_hd__dlclkp_1
* Process: SkyWater 130nm (1.80V VDD, 25 deg C)
* Operating Frequency: 100.0 MHz (Period = 10.0 ns)
*=============================================================================

.title SKY130 Integrated Clock Gating Transient Analysis

* Parameters
.param VDD_VOLT=1.80
.param CLK_PER=10.0n
.param CLK_PW=4.85n
.param SLEW=150p
.param C_LOAD=20f

* Power Rails
Vdd VPWR 0 DC {VDD_VOLT}
Vss VGND 0 DC 0.0

* 100 MHz Input Master Clock
Vclk CLK 0 PULSE(0 {VDD_VOLT} 0.5n {SLEW} {SLEW} {CLK_PW} {CLK_PER})

* Dynamic Sparsity Enable (0-25ns Active, 25-55ns Gated OFF, 55-80ns Active)
Ven GATE 0 PWL(0n {VDD_VOLT} 24n {VDD_VOLT} 25n 0.0 54n 0.0 55n {VDD_VOLT} 80n {VDD_VOLT})

* DFT Scan Bypass Test Pin
Vtest TEST 0 DC 0.0

* Qualified Enable (GATE OR TEST)
B_OR EN_QUAL 0 V = v(GATE) > 0.9 ? {VDD_VOLT} : (v(TEST) > 0.9 ? {VDD_VOLT} : 0.0)

* Glitch-Free Active-Low Transparent Latch Model
* When CLK < 0.9V, latch follows EN_QUAL. When CLK >= 0.9V, latch holds previous state.
B_LATCH LATCH_D 0 V = v(CLK) < 0.9 ? v(EN_QUAL) : v(LATCH_Q)
R_LATCH LATCH_D LATCH_Q 100
C_LATCH LATCH_Q 0 5f

* CMOS Gated Clock Driver Stage (measuring dynamic supply current)
M_P GCLK GCLK_BAR VPWR VPWR pmos_sw W=2.0u L=0.15u
M_N GCLK GCLK_BAR VGND VGND nmos_sw W=1.0u L=0.15u
.model pmos_sw pmos (level=1 vto=-0.5 kp=80u)
.model nmos_sw nmos (level=1 vto=0.5 kp=160u)

* Internal Inversion
B_INV GCLK_BAR 0 V = (v(CLK) > 0.9) && (v(LATCH_Q) > 0.9) ? 0.0 : {VDD_VOLT}
C_OUT GCLK 0 {C_LOAD}

* Current Sensing Resistor for Power Measurement
R_SENSE VPWR VPWR_INT 0.01

* Simulation Control
.control
  set wr_singlescale
  tran 20p 80n

  * Measure Clock-to-GCLK Propagation Delay at first rising edge
  meas tran t_clk_rise WHEN v(CLK)=0.9 RISE=1
  meas tran t_gclk_rise WHEN v(GCLK)=0.9 RISE=1
  let t_prop_delay = t_gclk_rise - t_clk_rise

  * Measure Peak and Gated Clock Voltages
  meas tran v_gclk_active_max MAX v(GCLK) from=5n to=20n
  meas tran v_gclk_gated_max MAX v(GCLK) from=30n to=50n

  * Measure Dynamic Current during Active vs Gated Periods
  meas tran i_active_avg AVG i(Vdd) from=5n to=25n
  meas tran i_gated_avg AVG i(Vdd) from=30n to=50n

  let p_active = abs(i_active_avg) * 1.80
  let p_gated = abs(i_gated_avg) * 1.80

  print t_prop_delay
  print v_gclk_active_max
  print v_gclk_gated_max
  print p_active
  print p_gated

  echo "=========================================================="
  echo "      NGSPICE SKY130 ICG CELL CHARACTERIZATION RESULTS   "
  echo "=========================================================="
  echo " Operating Frequency   : 100 MHz (10.0 ns Period)"
  echo " Standard Cell Target  : sky130_fd_sc_hd__dlclkp_1"
  echo " Supply Voltage (VDD)  : 1.80 V"
  echo " Temperature           : 25 C"
  echo " Output Load           : 20 fF"
  echo "----------------------------------------------------------"
  print t_prop_delay
  print v_gclk_active_max
  print v_gclk_gated_max
  print p_active
  print p_gated
  echo "=========================================================="

  wrdata /mnt/c/Users/sethu/Downloads/vlsi/ARe_UBNN_KWS/outputs/reports/ngspice_transient_data.txt v(CLK) v(GATE) v(GCLK)
.endc

.end
